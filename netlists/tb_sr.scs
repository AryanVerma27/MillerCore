// Design: EE6326_PROJECT/TB_SR
simulator lang=spectre
global 0
parameters vhi=1.3 vlo=0.8
include "/proj/cad/library/mosis/IBM_PDK/cmrf8sf/V1.8.0.4DM/Spectre/models/design.scs"
include "/proj/cad/library/mosis/IBM_PDK/cmrf8sf/V1.8.0.4DM/Spectre/models/allModels.scs" section=tt

// EE6326_PROJECT/AMPLIFIER/schematic
subckt AMPLIFIER GND INN INP OUT VDD
    M6 (OUT net2 VDD VDD) pfet33 l=1u w=10u nf=1 m=8 ngcon=1 rf_rsub=1 plnest=-1 pld200=-1 pwd100=-1 lstis=1 lnws=0 rgatemod=0 rbodymod=0 panw1=0p panw2=0p panw3=0p panw4=0p panw5=0p panw6=0p panw7=0p panw8=0p panw9=0p panw10=0p dtemp=0
    M4 (net2 net1 VDD VDD) pfet33 l=1u w=10u nf=1 m=1 ngcon=1 rf_rsub=1 plnest=-1 pld200=-1 pwd100=-1 lstis=1 lnws=0 rgatemod=0 rbodymod=0 panw1=0p panw2=0p panw3=0p panw4=0p panw5=0p panw6=0p panw7=0p panw8=0p panw9=0p panw10=0p dtemp=0
    M3 (net1 net1 VDD VDD) pfet33 l=1u w=10u nf=1 m=1 ngcon=1 rf_rsub=1 plnest=-1 pld200=-1 pwd100=-1 lstis=1 lnws=0 rgatemod=0 rbodymod=0 panw1=0p panw2=0p panw3=0p panw4=0p panw5=0p panw6=0p panw7=0p panw8=0p panw9=0p panw10=0p dtemp=0
    M7 (OUT net4 GND GND) nfet33 l=1u w=2.5u nf=1 m=8 ngcon=1 rf_rsub=1 plnest=-1 pld200=-1 pwd100=-1 lstis=1 lnws=0 rgatemod=0 rbodymod=0 panw1=0p panw2=0p panw3=0p panw4=0p panw5=0p panw6=0p panw7=0p panw8=0p panw9=0p panw10=0p dtemp=0
    M8 (net4 net4 GND GND) nfet33 l=1u w=2.5u nf=1 m=1 ngcon=1 rf_rsub=1 plnest=-1 pld200=-1 pwd100=-1 lstis=1 lnws=0 rgatemod=0 rbodymod=0 panw1=0p panw2=0p panw3=0p panw4=0p panw5=0p panw6=0p panw7=0p panw8=0p panw9=0p panw10=0p dtemp=0
    M5 (net3 net4 GND GND) nfet33 l=3u w=7.5u nf=1 m=2 ngcon=1 rf_rsub=1 plnest=-1 pld200=-1 pwd100=-1 lstis=1 lnws=0 rgatemod=0 rbodymod=0 panw1=0p panw2=0p panw3=0p panw4=0p panw5=0p panw6=0p panw7=0p panw8=0p panw9=0p panw10=0p dtemp=0
    M2 (net2 INP net3 GND) nfet33 l=2u w=4u nf=1 m=1 ngcon=1 rf_rsub=1 plnest=-1 pld200=-1 pwd100=-1 lstis=1 lnws=0 rgatemod=0 rbodymod=0 panw1=0p panw2=0p panw3=0p panw4=0p panw5=0p panw6=0p panw7=0p panw8=0p panw9=0p panw10=0p dtemp=0
    M1 (net1 INN net3 GND) nfet33 l=2u w=4u nf=1 m=1 ngcon=1 rf_rsub=1 plnest=-1 pld200=-1 pwd100=-1 lstis=1 lnws=0 rgatemod=0 rbodymod=0 panw1=0p panw2=0p panw3=0p panw4=0p panw5=0p panw6=0p panw7=0p panw8=0p panw9=0p panw10=0p dtemp=0
    I0 (VDD net4) isource dc=5u type=dc
    Rz (net2 net5) resistor r=5K
    Cc (net5 OUT) capacitor c=800f
ends AMPLIFIER

// EE6326_PROJECT/TB_SR/schematic
XAMP (0 OUT INP OUT VDD) AMPLIFIER
VDD0 (VDD 0) vsource dc=1.5 mag=1 type=dc
CL (OUT 0) capacitor c=2p
VP (INP 0) vsource type=pulse val0=vlo val1=vhi period=2u delay=100n rise=1n fall=1n width=1u
simulatorOptions options temp=27 tnom=25
tran tran stop=3u errpreset=conservative
