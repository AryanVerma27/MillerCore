// Design: EE6326_PROJECT/TB_SWING
simulator lang=spectre
global 0
parameters vcm=1 vs=0
include "/proj/cad/library/mosis/IBM_PDK/cmrf8sf/V1.8.0.4DM/Spectre/models/design.scs"
include "/proj/cad/library/mosis/IBM_PDK/cmrf8sf/V1.8.0.4DM/Spectre/models/allModels.scs" section=tt

// EE6326_PROJECT/AMPLIFIER/schematic
subckt AMPLIFIER GND INN INP OUT VDD
    M6 (OUT net2 VDD VDD) pfet33 l=1u w=10u nf=1 m=8 ngcon=1 rf_rsub=1 plnest=-1 pld200=-1 pwd100=-1 lstis=1 lnws=0 rgatemod=0 rbodymod=0 panw1=0p panw2=0p panw3=0p panw4=0p panw5=0p panw6=0p panw7=0p panw8=0p panw9=0p panw10=0p dtemp=0
    M4 (net2 net1 VDD VDD) pfet33 l=1u w=10u nf=1 m=1 ngcon=1 rf_rsub=1 plnest=-1 pld200=-1 pwd100=-1 lstis=1 lnws=0 rgatemod=0 rbodymod=0 panw1=0p panw2=0p panw3=0p panw4=0p panw5=0p panw6=0p panw7=0p panw8=0p panw9=0p panw10=0p dtemp=0
    M3 (net1 net1 VDD VDD) pfet33 l=1u w=10u nf=1 m=1 ngcon=1 rf_rsub=1 plnest=-1 pld200=-1 pwd100=-1 lstis=1 lnws=0 rgatemod=0 rbodymod=0 panw1=0p panw2=0p panw3=0p panw4=0p panw5=0p panw6=0p panw7=0p panw8=0p panw9=0p panw10=0p dtemp=0
    M7 (OUT net4 GND GND) nfet33 l=1u w=2.5u nf=1 m=8 ngcon=1 rf_rsub=1 plnest=-1 pld200=-1 pwd100=-1 lstis=1 lnws=0 rgatemod=0 rbodymod=0 panw1=0p panw2=0p panw3=0p panw4=0p panw5=0p panw6=0p panw7=0p panw8=0p panw9=0p panw10=0p dtemp=0
    M8 (net4 net4 GND GND) nfet33 l=1u w=2.5u nf=1 m=1 ngcon=1 rf_rsub=1 plnest=-1 pld200=-1 pwd100=-1 lstis=1 lnws=0 rgatemod=0 rbodymod=0 panw1=0p panw2=0p panw3=0p panw4=0p panw5=0p panw6=0p panw7=0p panw8=0p panw9=0p panw10=0p dtemp=0
    M5 (net3 net4 GND GND) nfet33 l=3u w=7.5u nf=1 m=2 ngcon=1 rf_rsub=1 plnest=-1 pld200=-1 pwd100=-1 lstis=1 lnws=0 rgatemod=0 rbodymod=0 panw1=0p panw2=0p panw3=0p panw4=0p panw5=0p panw6=0p panw7=0p panw8=0p panw9=0p panw10=0p dtemp=0
    M2 (net2 INP net3 GND) nfet33 l=2u w=4u nf=1 m=1 ngcon=1 rf_rsub=1 plnest=-1 pld200=-1 pwd100=-1 lstis=1 lnws=0 rgatemod=0 rbodymod=0 panw1=0p panw2=0p panw3=0p panw4=0p panw5=0p panw6=0p panw7=0p panw8=0p panw9=0p panw10=0p dtemp=0
    M1 (net1 INN net3 GND) nfet33 l=2u w=4u nf=1 m=1 ngcon=1 rf_rsub=1 plnest=-1 pld200=-1 pwd100=-1 lstis=1 lnws=0 rgatemod=0 rbodymod=0 panw1=0p panw2=0p panw3=0p panw4=0p panw5=0p panw6=0p panw7=0p panw8=0p panw9=0p panw10=0p dtemp=0
    I0 (VDD net4) isource dc=5u type=dc
    Rz (net2 net5) resistor r=5K
    Cc (net5 OUT) capacitor c=800f
ends AMPLIFIER

// EE6326_PROJECT/TB_SWING/schematic
XAMP (0 INN INP OUT VDD) AMPLIFIER
VS (vs 0) vsource dc=vs type=dc
VCM (CM 0) vsource dc=vcm type=dc
VDD0 (VDD 0) vsource dc=1.5 type=dc
CL (OUT 0) capacitor c=2p
E1 (INN CM vs 0) vcvs gain=-0.5
E0 (INP CM vs 0) vcvs gain=0.5
simulatorOptions options temp=27 tnom=25
dc dc param=vs start=-2m stop=2m step=1u
